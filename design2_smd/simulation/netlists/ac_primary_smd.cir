* Design 2 - surface-mount (modern, RIAA-exact)
.include models.lib
V24 V24 0 DC 24
VS IN 0 DC 0 AC 1
R1 IN 0 75000
C1 B1 IN 1e-06
R3 VCC B1F 165000
R26 B1F B1 165000
C10 B1F 0 1e-05
R2 B1 0 330000
R4 B1 B1A 470
C2 B1A 0 4.7e-10
Q1 N1 B1A E1 BC850C
R5 VCC N1 22000
Q2 N2 N1 E2 BC860C
R7 VCC E2 1000
R8 N2 0 22000
R9 N2 B3 1000
Q3 VCC B3 O1 BCX56
R10 O1 E1 1100
R6 E1 C3P 499
C3 C3P 0 0.00022
Q5 O1 Y1 Z1 BCX56
R11 VCC Y1 62000
Q4 Y1 Z1 0 BC850C
R13 Z1 0 68
R12 O1 B6 3400
C4 B6 0 2.2e-08
Q6 N6 B6 E6 BC850C
R14 VCC N6 22000
Q7 N7 N6 E7 BC860C
R18 VCC E7 1000
R19 N7 0 22000
R22 N7 B8 1000
Q8 VCC B8 O2 BCX56
R15 E6 0 220000
R16 E6 C5P 390
C5 C5P 0 0.00022
R17 E6 F2 4700
R21 F2 O2 63400
C6 F2 O2 6.8e-08
Q10 O2 Y2 Z2 BCX56
R23 VCC Y2 62000
Q9 Y2 Z2 0 BC850C
R20 Z2 0 68
C7 O2 OUT 4.7e-05
R24 OUT 0 100000
R25 V24 VCC 68
C8 VCC 0 0.00047
C9 VCC 0 1e-07
RLOAD OUT 0 47000
.options savecurrents reltol=1e-5 vntol=1e-8 abstol=1e-14
.control
ac dec 50 1 200000
let mag=abs(v(out))
let ph=cph(v(out))
let zin=abs(v(in)/(-i(vs)))
let zinph=cph(v(in)/(-i(vs)))
wrdata ac_primary.txt mag ph zin zinph
.endc

.end
